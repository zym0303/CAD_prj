TwoStage_opamp_netlist

.include "ngspice_interface/files/spice_models/p045_TT.sp"

.param wp1=1.5e-06 lp1=1.35e-07 mp1=20
.param wn1=7.5e-07 ln1=1.8e-07 mn1=16
.param wn3=5e-07 ln3=9e-08 mn3=10
.param wp3=5e-07 lp3=4.5e-08 mp3=14
.param wn4=2.25e-06 ln4=9e-08 mn4=6
.param wn5=2.25e-06 ln5=1.35e-07 mn5=22
.param cap=5e-13
.param res=5600.0

.param ibias=30u
.param cload=10p
.param vcm=0.6

.param VDD=1.2
* 27 degC: reproduces the TA reference designs (same as circuit_env.py pvt_corner); at 25 degC design 1 gain/noise differ by ~7.8 %
.param temp_pvt=27
.param trf=0.5u
.param period=10u
.param vhigh=VDD

mp1 net4 net4 VDD VDD pmos w=wp1 l=lp1 m=mp1
mp2 net5 net4 VDD VDD pmos w=wp1 l=lp1 m=mp1
mn1 net4 net2 net3 net3 nmos w=wn1 l=ln1 m=mn1
mn2 net5 net1 net3 net3 nmos w=wn1 l=ln1 m=mn1
mn3 net7 net7 VSS VSS nmos w=wn3 l=ln3 m=mn3
mn4 net3 net7 VSS VSS nmos w=wn4 l=ln4 m=mn4
mp3 net6 net5 VDD VDD pmos w=wp3 l=lp3 m=mp3
mn5 net6 net7 VSS VSS nmos w=wn5 l=ln5 m=mn5
cc net5 net8 {cap}
rc net8 net6 {res}

ibias VDD net7 ibias

Vicm VCM VSS dc=vcm
Vinput aid VSS dc=0.0 ac=1.0 PULSE({-VHIGH/2} {VHIGH/2} {trf} {trf} {trf} {0.5*period-trf} {period})
ein1 net1 VCM aid 0 0.5
ein2 net2 VCM aid 0 -0.5

vdd VDD 0 dc=VDD
vss VSS 0 dc=0
CL net6 0 {cload}

* set temperature
.temp {temp_pvt}

.control
run
set units=degrees
set wr_vecnames
option numdgt=7

* transient analysis (1 ns step: same as the TA reference designs; 50 ns underestimates fast slew rates)
tran 1n 30u
* save Vout data in a file named 'tran_TwoStage.csv'
wrdata /Users/afonsodemello/Documents/University/Masters/KU_Leuven/MSc_Electrical_Engineering/Year_2/Semester_1/Computer-Aided_IC_Design/Project/code/CAD/no_backup/output_files/tran_TwoStage_1793830783_tpempdqkhr.csv v(net6)

* ac analysis
ac dec 10 1 1T
* save Vout data in a file named 'ac_TwoStage.csv'
wrdata /Users/afonsodemello/Documents/University/Masters/KU_Leuven/MSc_Electrical_Engineering/Year_2/Semester_1/Computer-Aided_IC_Design/Project/code/CAD/no_backup/output_files/ac_TwoStage_1793830783_tpempdqkhr.csv v(net6)

* noise analysis
* calculate the output noise and save it in a file named 'noise_TwoStage.csv'
noise v(net6) vinput dec 10 1 1T
wrdata /Users/afonsodemello/Documents/University/Masters/KU_Leuven/MSc_Electrical_Engineering/Year_2/Semester_1/Computer-Aided_IC_Design/Project/code/CAD/no_backup/output_files/noise_TwoStage_1793830783_tpempdqkhr.csv onoise_total

* dc analysis
op
* save the total current consumption in a file named 'dc_TwoStage.csv'
wrdata /Users/afonsodemello/Documents/University/Masters/KU_Leuven/MSc_Electrical_Engineering/Year_2/Semester_1/Computer-Aided_IC_Design/Project/code/CAD/no_backup/output_files/dc_TwoStage_1793830783_tpempdqkhr.csv i(vdd)

.endc

.end
